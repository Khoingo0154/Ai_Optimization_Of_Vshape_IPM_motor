# Ansys Electronics Desktop project, version 2022.2
materials:
  M19_29G: permeability{HUnit=A_per_meter BUnit=tesla curve (0, 0) (22.28, 0.05) (25.46, 0.1) (31.83, 0.15) (47.74, 0.36) (63.66, 0.54) (79.57, 0.65) (159.15, 0.99) (318.3, 1.2) (477.46, 1.28) (636.61, 1.33) (795.77, 1.36) (1591.5, 1.44) (3183, 1.52) (4774.6, 1.58) (6366.1, 1.63) (7957.7, 1.67) (15915, 1.8) (31830, 1.9) (111407, 2) (190984, 2.1) (350138, 2.3) (509292, 2.5)} conductivity=1960000 core_loss_type="Electrical Steel" core_loss_kh=164.2 core_loss_kc=0.409 mass_density=7650
  NdFe35_N: permittivity=1 permeability=1.0997785 conductivity=625000 magnetic_coercivity{Magnitude=-890000A_per_meter DirComp1=1 DirComp2=0 DirComp3=0} lande_g_factor=2 magnetostriction{PropertyModelType=0 Dir1ModelType=0 Dir2ModelType=0 IsoCoeff=0 IsoHMax=0A_per_meter IsoHMin=0A_per_meter Dir1Coeff=0 Dir1HMax=0A_per_meter Dir1HMin=0A_per_meter Dir1VecX=1 Dir1VecY=0 Dir1VecZ=0 Dir2Coeff=0 Dir2HMax=0A_per_meter Dir2HMin=0A_per_meter Magnetostriction{Isotropic{OneVariation{DatasetMapsName="Lambda-H curves versus Stress"}} Direction1{OneVariation{DatasetMapsName="Lambda-H curves versus Stress"}} Direction2{OneVariation{DatasetMapsName="Lambda-H curves versus Stress"}} SelectedDatasetMapsName="Lambda-H curves versus Stress"}}
  NdFe35_S: permittivity=1 permeability=1.0997785 conductivity=625000 magnetic_coercivity{Magnitude=-890000A_per_meter DirComp1=-1 DirComp2=0 DirComp3=0} lande_g_factor=2 magnetostriction{PropertyModelType=0 Dir1ModelType=0 Dir2ModelType=0 IsoCoeff=0 IsoHMax=0A_per_meter IsoHMin=0A_per_meter Dir1Coeff=0 Dir1HMax=0A_per_meter Dir1HMin=0A_per_meter Dir1VecX=1 Dir1VecY=0 Dir1VecZ=0 Dir2Coeff=0 Dir2HMax=0A_per_meter Dir2HMin=0A_per_meter Magnetostriction{Isotropic{OneVariation{DatasetMapsName="Lambda-H curves versus Stress"}} Direction1{OneVariation{DatasetMapsName="Lambda-H curves versus Stress"}} Direction2{OneVariation{DatasetMapsName="Lambda-H curves versus Stress"}} SelectedDatasetMapsName="Lambda-H curves versus Stress"}}
  copper: permeability=0.999991 conductivity=58000000
  vacuum: permittivity=1

design Vshape_IPM (Maxwell 2D, Transient, XY geometry, model units mm)
options: ModelDepth=Lstk
variables:
  # Rotor Variables
  Dr_out = Ds_in-2*air_gap
  Dr_in = 80mm
  Lstk = 134mm
  Speed_rpm = 120*f0/PolesNum rpm
  # Airgap Variables
  air_gap = 1mm
  lamda = 0.9
  D_ag = Lstk/lamda
  # Stator Variables
  Ds_out = 240mm
  Ds_in = D_ag + air_gap
  bridge = 1.5mm
  # Stator Slot Variables
  SlotNum = 36
  Aslot = 216.0873mm2
  hs0 = 1.1899mm
  hs1 = 1.5mm
  hs2 = 18.0766mm
  bs0 = 2.1128mm
  bs1 = 6.9014mm
  bs2 = 10.8808mm
  # Rotor Poles Variables
  PolesNum = 6
  o1 = 5.4mm
  o2 = 6mm
  b1 = 3.5mm
  rib = 2mm
  hrib = 2.4mm
  mt = 5.282mm
  mw = 31.802mm
  magDmin = 10mm
  # Winding Variables
  Acond = Imax/J mm2
  N = max(N_onLoad, 10)
  N_onLoad = int(0.7*Aslot/Acond)+1
  # Current Excitation Variables
  Imax = 82A
  J = 5.5A
  f0 = 100Hz
  t0 = 0ms
  thet = (thet_deg*pi/180) rad
  thet_deg = 30deg
  # Weights
  Wcopper = 8960kg_per_m3
  Wmagnet = 7500kg_per_m3
  Wsteel = 7650kg_per_m3
  # Costs
  Ccopper = 13.3
  Cmagnet = 29
  Csteel = 2
geometry:
  Stator [M19_29G] = user_primitive(RMxprt/SlotCore.dll, DiaGap=Ds_in, DiaYoke=Ds_out, Length=0, Skew=0deg, Slots=SlotNum, SlotType=2, Hs0=hs0, Hs01=0mm, Hs1=hs1, Hs2=hs2, Bs0=bs0, Bs1=bs1, Bs2=bs2, Rs=5mm, FilletType=0, HalfSlot=0, SegAngle=15deg, LenRegion=200mm, InfoCore=0)
  Rotor [M19_29G] = user_primitive(RMxprt/IPMCore.dll, DiaGap=Dr_out, DiaYoke=Dr_in, Length=0, Poles=PolesNum, PoleType=4, D1=Ds_in-2*air_gap-2*bridge, O1=o1, O2=o2, B1=b1, Rib=rib, HRib=hrib, DminMag=magDmin, ThickMag=mt, WidthMag=mw, LenRegion=200mm, InfoCore=0)
  Region [vacuum] = circle(normal=Z, centre=(0mm, 0mm, 0mm), radius=0.0075+Ds_out/2)
  Band [vacuum] = circle(normal=Z, centre=(0mm, 0mm, 0mm), radius=D_ag/2)
  AP [copper] = user_primitive(RMxprt/LapCoil.dll, DiaGap=Ds_in, DiaYoke=Ds_out, Length=0mm, Skew=0deg, Slots=36, SlotType=2, Hs0=hs0, Hs1=hs1, Hs2=hs2, Bs0=bs0, Bs1=bs1, Bs2=bs2, Rs=5mm, FilletType=0, Layers=1, CoilPitch=4, EndExt=5mm, SpanExt=25mm, BendAngle=0deg, SegAngle=10deg, LenRegion=200mm, InfoCoil=1)
  AP.separate_bodies()
  AP_1 [copper] = AP.duplicate_around_axis(axis=Z, angle=(360/36) deg, total=2)
  CN, BP [copper] = AP.duplicate_around_axis(axis=Z, angle=(360/18) deg, total=3)
  CN_1, BP_1 [copper] = AP_1.duplicate_around_axis(axis=Z, angle=(360/18) deg, total=3)
  CP [copper] = CN_1.duplicate_around_axis(axis=Z, angle=(360/6) deg, total=2)
  CP_1 [copper] = CN.duplicate_around_axis(axis=Z, angle=(360/6) deg, total=2)
  BN [copper] = BP_1.duplicate_around_axis(axis=Z, angle=(360/6) deg, total=2)
  BN_1 [copper] = BP.duplicate_around_axis(axis=Z, angle=(360/6) deg, total=2)
  AN [copper] = AP_1.duplicate_around_axis(axis=Z, angle=(360/6) deg, total=2)
  AN_1 [copper] = AP.duplicate_around_axis(axis=Z, angle=(360/6) deg, total=2)
  CP_1_1, CP_1_2 [copper] = CP_1.duplicate_around_axis(axis=Z, angle=(360/3) deg, total=3)
  CP_2, CP_3 [copper] = CP.duplicate_around_axis(axis=Z, angle=(360/3) deg, total=3)
  CN_1_1, CN_1_2 [copper] = CN_1.duplicate_around_axis(axis=Z, angle=(360/3) deg, total=3)
  CN_2, CN_3 [copper] = CN.duplicate_around_axis(axis=Z, angle=(360/3) deg, total=3)
  BP_1_1, BP_1_2 [copper] = BP_1.duplicate_around_axis(axis=Z, angle=(360/3) deg, total=3)
  BP_2, BP_3 [copper] = BP.duplicate_around_axis(axis=Z, angle=(360/3) deg, total=3)
  BN_1_1, BN_1_2 [copper] = BN_1.duplicate_around_axis(axis=Z, angle=(360/3) deg, total=3)
  BN_2, BN_3 [copper] = BN.duplicate_around_axis(axis=Z, angle=(360/3) deg, total=3)
  AP_1_1, AP_1_2 [copper] = AP_1.duplicate_around_axis(axis=Z, angle=(360/3) deg, total=3)
  AP_2, AP_3 [copper] = AP.duplicate_around_axis(axis=Z, angle=(360/3) deg, total=3)
  AN_1_1, AN_1_2 [copper] = AN_1.duplicate_around_axis(axis=Z, angle=(360/3) deg, total=3)
  AN_2, AN_3 [copper] = AN.duplicate_around_axis(axis=Z, angle=(360/3) deg, total=3)
  Rotor.rotate(axis=Z, angle=-20deg)
  Circle1 = circle(normal=Z, centre=(0mm, 0mm, 0mm), radius=Ds_in/2)
  statorWslots [vacuum] = circle(normal=Z, centre=(0mm, 0mm, 0mm), radius=Ds_out/2)
  statorWslots.subtract(Circle1)
  N_magnets_5 [NdFe35_N, oriented by FaceCS10] = user_primitive(RMxprt/IPMCore.dll, DiaGap=Dr_out, DiaYoke=Dr_in, Length=0mm, Poles=PolesNum, PoleType=4, D1=Ds_in-2*air_gap-2*bridge, O1=o1, O2=o2, B1=b1, Rib=rib, HRib=hrib, DminMag=magDmin, ThickMag=mt, WidthMag=mw, LenRegion=200mm, InfoCore=1)
  N_magnets [NdFe35_N, oriented by FaceCS9], N_magnets_2 [NdFe35_N, oriented by FaceCS6], N_magnets_1 [NdFe35_N, oriented by FaceCS5], N_magnets_4 [NdFe35_N, oriented by FaceCS1], N_magnets_3 [NdFe35_N, oriented by FaceCS2], S_Magnets_2 [NdFe35_S, oriented by FaceCS3], S_Magnets_1 [NdFe35_S, oriented by FaceCS4], S_Magnets [NdFe35_S, oriented by FaceCS7], S_Magnets_3 [NdFe35_S, oriented by FaceCS8], S_Magnets_4 [NdFe35_S, oriented by FaceCS11], S_Magnets_5 [NdFe35_S, oriented by FaceCS12] = N_magnets_5.separate_bodies()
  [N_magnets, N_magnets_2, N_magnets_1, N_magnets_4, N_magnets_3, S_Magnets_2, S_Magnets_1, S_Magnets, S_Magnets_3, S_Magnets_4, S_Magnets_5, N_magnets_5].rotate(axis=Z, angle=-20deg)
  coordinate_system FaceCS1 = face of N_magnets_4: Origin=(54.570451, 17.575949, 0) MoveToEnd FaceID=N_magnets_5.face(5 of 12) AxisPosn=(56.732096, 22.39537, 0) WhichAxis=X ZRotationAngle=0deg XOffset=0mm YOffset=0mm
  coordinate_system FaceCS2 = face of N_magnets_3: Origin=(26.784991, 50.689372, 0) MoveToEnd FaceID=N_magnets_5.face(6 of 12) AxisPosn=(31.906559, 51.981293, 0) WhichAxis=X ZRotationAngle=0deg XOffset=0mm YOffset=0mm
  coordinate_system FaceCS3 = face of S_Magnets_2: Origin=(12.064007, 56.047372, 0) MoveToEnd FaceID=N_magnets_5.face(7 of 12) AxisPosn=(8.9710886, 60.329121, 0) WhichAxis=X ZRotationAngle=0deg XOffset=0mm YOffset=0mm
  coordinate_system FaceCS4 = face of S_Magnets_1: Origin=(-30.505788, 48.541168, 0) MoveToEnd FaceID=N_magnets_5.face(8 of 12) AxisPosn=(-29.063841, 53.622537, 0) WhichAxis=X ZRotationAngle=0deg XOffset=0mm YOffset=0mm
  coordinate_system FaceCS5 = face of N_magnets_1: Origin=(-42.506444, 38.471422, 0) MoveToEnd FaceID=N_magnets_5.face(4 of 12) AxisPosn=(-47.761007, 37.933751, 0) WhichAxis=X ZRotationAngle=0deg XOffset=0mm YOffset=0mm
  coordinate_system FaceCS6 = face of N_magnets_2: Origin=(-57.290779, -2.1482035, 0) MoveToEnd FaceID=N_magnets_5.face(3 of 12) AxisPosn=(-60.9704, 1.6412444, 0) WhichAxis=X ZRotationAngle=0deg XOffset=0mm YOffset=0mm
  coordinate_system FaceCS7 = face of S_Magnets: Origin=(-54.570451, -17.575949, 0) MoveToEnd FaceID=N_magnets_5.face(9 of 12) AxisPosn=(-56.732096, -22.39537, 0) WhichAxis=X ZRotationAngle=0deg XOffset=0mm YOffset=0mm
  coordinate_system FaceCS8 = face of S_Magnets_3: Origin=(-26.784991, -50.689372, 0) MoveToEnd FaceID=N_magnets_5.face(10 of 12) AxisPosn=(-31.906559, -51.981293, 0) WhichAxis=X ZRotationAngle=0deg XOffset=0mm YOffset=0mm
  coordinate_system FaceCS9 = face of N_magnets: Origin=(-12.064007, -56.047372, 0) MoveToEnd FaceID=N_magnets_5.face(2 of 12) AxisPosn=(-8.9710886, -60.329121, 0) WhichAxis=X ZRotationAngle=0deg XOffset=0mm YOffset=0mm
  coordinate_system FaceCS10 = face of N_magnets_5: Origin=(30.505788, -48.541168, 0) MoveToEnd FaceID=N_magnets_5.face(1 of 12) AxisPosn=(29.063841, -53.622537, 0) WhichAxis=X ZRotationAngle=0deg XOffset=0mm YOffset=0mm
  coordinate_system FaceCS11 = face of S_Magnets_4: Origin=(42.506444, -38.471422, 0) MoveToEnd FaceID=N_magnets_5.face(11 of 12) AxisPosn=(47.761007, -37.933751, 0) WhichAxis=X ZRotationAngle=0deg XOffset=0mm YOffset=0mm
  coordinate_system FaceCS12 = face of S_Magnets_5: Origin=(57.290779, 2.1482035, 0) MoveToEnd FaceID=N_magnets_5.face(12 of 12) AxisPosn=(60.9704, -1.6412444, 0) WhichAxis=X ZRotationAngle=0deg XOffset=0mm YOffset=0mm
motion:
  MotionSetup1: Band Move_Type=Rotate Coordinate_System=Global Axis=Z Is_Positive=true InitPos=0deg Angular_Velocity=Speed_rpm Objects=Band
  Moving1: Moving Objects=[Rotor, N_magnets_5, N_magnets, N_magnets_2, N_magnets_1, N_magnets_4, N_magnets_3, S_Magnets_2, S_Magnets_1, S_Magnets, S_Magnets_3, S_Magnets_4, S_Magnets_5]
boundaries and excitations:
  VectorPotential1: Vector Potential Edges=Region.edge(1 of 1) Value=0
  AN: Coil Objects=AN Conductor_number=N Winding=PhaseA PolarityType=Negative
  AN_1: Coil Objects=AN_1 Conductor_number=N Winding=PhaseA PolarityType=Negative
  AN_1_1: Coil Objects=AN_1_1 Conductor_number=N Winding=PhaseA PolarityType=Negative
  AN_1_2: Coil Objects=AN_1_2 Conductor_number=N Winding=PhaseA PolarityType=Negative
  AN_2: Coil Objects=AN_2 Conductor_number=N Winding=PhaseA PolarityType=Negative
  AN_3: Coil Objects=AN_3 Conductor_number=N Winding=PhaseA PolarityType=Negative
  AP: Coil Objects=AP Conductor_number=N Winding=PhaseA PolarityType=Positive
  AP_1: Coil Objects=AP_1 Conductor_number=N Winding=PhaseA PolarityType=Positive
  AP_1_1: Coil Objects=AP_1_1 Conductor_number=N Winding=PhaseA PolarityType=Positive
  AP_1_2: Coil Objects=AP_1_2 Conductor_number=N Winding=PhaseA PolarityType=Positive
  AP_2: Coil Objects=AP_2 Conductor_number=N Winding=PhaseA PolarityType=Positive
  AP_3: Coil Objects=AP_3 Conductor_number=N Winding=PhaseA PolarityType=Positive
  BN: Coil Objects=BN Conductor_number=N Winding=PhaseB PolarityType=Negative
  BN_1: Coil Objects=BN_1 Conductor_number=N Winding=PhaseB PolarityType=Negative
  BN_1_1: Coil Objects=BN_1_1 Conductor_number=N Winding=PhaseB PolarityType=Negative
  BN_1_2: Coil Objects=BN_1_2 Conductor_number=N Winding=PhaseB PolarityType=Negative
  BN_2: Coil Objects=BN_2 Conductor_number=N Winding=PhaseB PolarityType=Negative
  BN_3: Coil Objects=BN_3 Conductor_number=N Winding=PhaseB PolarityType=Negative
  BP: Coil Objects=BP Conductor_number=N Winding=PhaseB PolarityType=Positive
  BP_1: Coil Objects=BP_1 Conductor_number=N Winding=PhaseB PolarityType=Positive
  BP_1_1: Coil Objects=BP_1_1 Conductor_number=N Winding=PhaseB PolarityType=Positive
  BP_1_2: Coil Objects=BP_1_2 Conductor_number=N Winding=PhaseB PolarityType=Positive
  BP_2: Coil Objects=BP_2 Conductor_number=N Winding=PhaseB PolarityType=Positive
  BP_3: Coil Objects=BP_3 Conductor_number=N Winding=PhaseB PolarityType=Positive
  CN: Coil Objects=CN Conductor_number=N Winding=PhaseC PolarityType=Negative
  CN_1: Coil Objects=CN_1 Conductor_number=N Winding=PhaseC PolarityType=Negative
  CN_1_1: Coil Objects=CN_1_1 Conductor_number=N Winding=PhaseC PolarityType=Negative
  CN_1_2: Coil Objects=CN_1_2 Conductor_number=N Winding=PhaseC PolarityType=Negative
  CN_2: Coil Objects=CN_2 Conductor_number=N Winding=PhaseC PolarityType=Negative
  CN_3: Coil Objects=CN_3 Conductor_number=N Winding=PhaseC PolarityType=Negative
  CP: Coil Objects=CP Conductor_number=N Winding=PhaseC PolarityType=Positive
  CP_1: Coil Objects=CP_1 Conductor_number=N Winding=PhaseC PolarityType=Positive
  CP_1_1: Coil Objects=CP_1_1 Conductor_number=N Winding=PhaseC PolarityType=Positive
  CP_1_2: Coil Objects=CP_1_2 Conductor_number=N Winding=PhaseC PolarityType=Positive
  CP_2: Coil Objects=CP_2 Conductor_number=N Winding=PhaseC PolarityType=Positive
  CP_3: Coil Objects=CP_3 Conductor_number=N Winding=PhaseC PolarityType=Positive
  PhaseA: Winding Group Type=Current IsSolid=false Current=Imax*sin(2*pi*f0*(Time-t0)+thet) ParallelBranchesNum=1
  PhaseB: Winding Group Type=Current IsSolid=false Current=Imax*sin(2*pi*f0*(Time-t0)-2*pi/3+thet) ParallelBranchesNum=1
  PhaseC: Winding Group Type=Current IsSolid=false Current=Imax*sin(2*pi*f0*(Time-t0)+2*pi/3+thet) ParallelBranchesNum=1
mesh:
  Mesh: LengthBased RefineInside Objects=[Stator, Rotor, Region] MaxLength=3mm
  CylindricalGap1: CylindricalGap Objects=Band
  initial mesh: MeshMethod=AnsoftTAU
setups:
  Setup1: Transient NonlinearSolverResidual=0.0001 StopTime=20ms TimeStep=0.1ms SaveFieldsType="Every N Steps" N_Steps=10 Steps_From=0s Steps_To=20ms NumberSolveSteps=1 RangeStart=0s RangeEnd=0.1s InitialTimeStep=0.002s MinTimeStep=0.001s MaxTimeStep=0.003s TimeStepErrTolerance=0.0001
  parametric: Transient NonlinearSolverResidual=0.0001 StopTime=0.3ms TimeStep=0.1ms InitialTimeStep=0.002s MinTimeStep=0.001s MaxTimeStep=0.003s TimeStepErrTolerance=0.0001
optimetrics:
  Optimization: Parametric InterpolationPoints=0 Sim._Setups=[parametric]
    sweep Dr_in: LIN 50mm 90mm 5mm
    sweep lamda: LIN 0.8 1 0.1
    sweep bridge: LIN 1mm 3mm 0.4mm
    sweep air_gap: LIN 0.5mm 1.5mm 0.2mm
    calculate mean(Efficiency) on parametric : Transient at Time all
    calculate mean(TorqueRipple) on parametric : Transient at Time all
    calculate mean(Pout) on parametric : Transient at Time all
    calculate mean(PowerDensity) on parametric : Transient at Time all
    calculate mean(TotalCost) on parametric : Transient at Time all
output variables:
  TorqueRipple = (100*pk2pk(Moving1.Torque))/Moving1.Torque percent
  Efficiency = (100*Moving1.Torque*Moving1.Speed)/(Moving1.Torque*Moving1.Speed+StrandedLoss) percent
  Pin = InducedVoltage(PhaseA)*InputCurrent(PhaseA)+InducedVoltage(PhaseB)*InputCurrent(PhaseB)+InducedVoltage(PhaseC)*InputCurrent(PhaseC) W
  Pout = Moving1.Torque*Moving1.Speed W
  Efficiency2 = 100*Pout/Pin percent
  TotalCost = (SlotNum*Area(AP)*Wcopper*Ccopper+PolesNum*Area(N_magnets_1)*Wmagnet*Cmagnet+(Area(Stator)+Area(Rotor))*Wsteel*Csteel)*Lstk
  PowerDensity = Pout/TotalWeight W
  TotalWeight = (SlotNum*Area(AP)*Wcopper+PolesNum*Area(N_magnets_1)*Wmagnet+(Area(Stator)+Area(Rotor))*Wsteel)*Lstk kg
  AreaOfSlot = (Area(statorWslots)-Area(Stator))/SlotNum
field calculator expressions:
  B_rad = Fundamental_Quantity(22) | Vector_Function(FuncValueX='0mm', FuncValueY='0mm', FuncValueZ='0mm') | ToCylindrical | ScalarX
  B_tan = Fundamental_Quantity(22) | Vector_Function(FuncValueX='0mm', FuncValueY='0mm', FuncValueZ='0mm') | ToCylindrical | ScalarY
reports:
  Torque: Moving1.Torque vs Time on Setup1 : Transient
  Three-Phase Flux Linkage: FluxLinkage(PhaseA), FluxLinkage(PhaseB), FluxLinkage(PhaseC) vs Time on Setup1 : Transient
  Three-Phase Back EMF: InducedVoltage(PhaseA), InducedVoltage(PhaseB), InducedVoltage(PhaseC) vs Time on Setup1 : Transient [Imax=all]
  Rotor Speed: Moving1.Speed vs Time on Setup1 : Transient [Imax=all t0=all]
  Input Current: InputCurrent(PhaseA), InputCurrent(PhaseB), InputCurrent(PhaseC) vs Time on Setup1 : Transient [Imax=all t0=all]
  Torque Ripples: TorqueRipple vs Time on Setup1 : Transient [t0=all]
  Efficiency: Efficiency vs Time on Setup1 : Transient [J=all t0=all]
  Power: Pin, Pout vs Time on Setup1 : Transient [Dr_in=all air_gap=all lamda=all bridge=all]
  OutputVariablesTable: TorqueRipple, Efficiency, Pin, Pout, TotalCost, PowerDensity, TotalWeight, Moving1.Torque, FluxLinkage(PhaseA), FluxLinkage(PhaseB), FluxLinkage(PhaseC), InducedVoltage(PhaseA), InducedVoltage(PhaseB), InducedVoltage(PhaseC) vs Time on Setup1 : Transient [Dr_in=all air_gap=all lamda=all bridge=all]
